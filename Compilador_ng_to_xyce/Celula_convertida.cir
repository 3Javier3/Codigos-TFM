* --- Parametros ---
* Fotocorriente
* .PARAM Iph_val=3.5 (expandido en componentes)

* Corriente de saturación inversa del diodo
* .PARAM Is_val=1e-9 (expandido en componentes)

* Factor de idealidad (1=perfecto, 2=muchas perdidas)
* .PARAM N_val=1.5 (expandido en componentes)

* Resistencia serie
* .PARAM Rs_val=0.05 (expandido en componentes)

* Resistencia paralelo
* .PARAM Rsh_val=500 (expandido en componentes)

* --- Circuito ---
Iph 0 1 3.5
D1 1 0 ModeloDiodo1
Rsh 1 0 500
Rs 1 2 0.05
Vload 2 0 0V

.MODEL ModeloDiodo1 D (IS=1e-9 N=1.5)

* --- Ejecucion ---
* --- Bloque .control eliminado (no soportado en Xyce) ---
    * 1. Ejecutar barrido DC
* [CONTROL]     dc Vload 0 0.9 0.005

    * 2. Calcular la Potencia
* [CONTROL]     let potencia = -v(2) * i(vload)

    * 3. Graficas
* [CONTROL]     plot -i(vload) title 'Curva I-V (A)'
* [CONTROL]     plot potencia title 'Curva P-V (W)'

    * 4. Guardar datos para graficar en Python
* [CONTROL]     wrdata resultados_ngspice.txt -i(vload) potencia
* --- Fin del bloque .control ---

* --- Análisis (extraído de .control) ---
.DC vload 0 0.9 0.005
.PRINT DC V(2) I(vload)

.END
