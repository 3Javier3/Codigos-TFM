* --- Parametros ---
* Fotocorriente
.param Iph_val=3.5

* Corriente de saturación inversa del diodo
.param Is_val=1e-9

* Factor de idealidad (1=perfecto, 2=muchas perdidas)
.param N_val=1.5

* Resistencia serie
.param Rs_val=0.05

* Resistencia paralelo
.param Rsh_val=500

* --- Circuito ---
Iph 0 1 {Iph_val}
D1 1 0 ModeloDiodo1
Rsh 1 0 {Rsh_val}
Rs 1 2 {Rs_val}
Vload 2 0 0V

.model ModeloDiodo1 D (IS={Is_val} N={N_val})

* --- Ejecucion ---
.control
    * 1. Ejecutar barrido DC
    dc Vload 0 0.9 0.005

    * 2. Calcular la Potencia
    let potencia = -v(2) * i(vload)

    * 3. Graficas
    plot -i(vload) title 'Curva I-V (A)'
    plot potencia title 'Curva P-V (W)'

    * 4. Guardar datos para graficar en Python
    wrdata resultados_ngspice.txt -i(vload) potencia
.endc

.end
