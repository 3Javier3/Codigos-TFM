* Modelo de Célula Solar - Coincidencia con modelo matemático
.OPTIONS DEVICE WIDTH=100

* --- Parámetros del Circuito ---
* Iph = 3.5A
Iph 0 1 3.5

* Diodo con IS=1e-9 y N=1.5
D1 1 0 ModeloTFM

* Rsh = 500 Ohmios
Rsh 1 0 500

* Rs = 0.05 Ohmios
Rs 1 2 0.05

* Carga variable (Barrido de 0V a 0.9V)
Vload 2 0 0V

* --- Definición del Modelo ---
* IS: Corriente de saturación inversa
* N: Factor de idealidad
.MODEL ModeloTFM D (IS=1e-9 N=1.5)

* --- Análisis ---
.DC Vload 0 0.9 0.005
.PRINT DC V(2) I(Rs)
.END
