* Modelo de Célula Solar Xyce
.OPTIONS DEVICE WIDTH=100

Iph 0 1 3.5

* Diodo con IS=1e-9 y N=1.5
D1 1 0 ModeloTFM

Rsh 1 0 500
Rs 1 2 0.05

* Carga variable (Barrido de 0V a 0.9V)
Vload 2 0 0V

* IS: Corriente de saturación inversa
* N: Factor de idealidad
.MODEL ModeloTFM D (IS=1e-9 N=1.5)

.DC Vload 0 0.9 0.005
.PRINT DC V(2) I(Rs)
.END
